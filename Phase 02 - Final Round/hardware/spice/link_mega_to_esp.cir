* Mega TX2 -> 1k8/3k3 divider -> ESP32-CAM GPIO15 (R3, R4 on the PCB deck)
Vtx tx 0 PWL(0 5 2e-06 5 2.01e-06 0 6e-06 0 6.01e-06 5 1e-05 5 1.001e-05 0 1.4e-05 0 1.401e-05 5 1.8e-05 5 1.801e-05 0 2.6e-05 0 2.601e-05 5 3e-05 5 3.001e-05 0 3.4e-05 0 3.401e-05 5 4.2e-05 5 4.201e-05 0 5e-05 0 5.001e-05 5 5.4e-05 5 5.401e-05 0 5.8e-05 0 5.801e-05 5 6.6e-05 5 6.601e-05 0 7e-05 0 7.001e-05 5 7.4e-05 5 7.401e-05 0 7.8e-05 0 7.801e-05 5 8.2e-05 5 8.201e-05 0 0.000118 0 0.000118 5 0.000122 5 0.000122 0 0.000126 0 0.000126 5 0.000162 5 0.000162 0 0.000166 0 0.000166 5 0.00017 5 0.00017 0 0.000174 0 0.000174 5 0.000178 5 0.000178 0 0.000182 0 0.000182 5 0.000186 5 0.000186 0 0.00019 0 0.00019 5 0.000194 5 0.000194 0 0.000198 0 0.000198 5 0.000204 5)
Rout tx a 25
R3 a rx 1.8k
R4 rx 0 3.3k
Ccable rx 0 30p
Cesp rx 0 5p
.tran 10n 0.000204
.control
run
wrdata _link_mega_to_esp.txt v(tx) v(rx)
.endc
.end
