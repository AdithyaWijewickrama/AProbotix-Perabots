* ESP32-CAM GPIO14 (3.3 V) -> 2N7000 (Q1) -> Mega RX2, pull-ups R5 10k to 3V3, R6 10k to 5 V
.include models.lib
V33 v33 0 3.3
V5 v5 0 5
Vtx txi 0 PWL(0 3.3 2e-06 3.3 2.01e-06 0 6e-06 0 6.01e-06 3.3 1e-05 3.3 1.001e-05 0 1.4e-05 0 1.401e-05 3.3 1.8e-05 3.3 1.801e-05 0 2.6e-05 0 2.601e-05 3.3 3e-05 3.3 3.001e-05 0 3.4e-05 0 3.401e-05 3.3 4.2e-05 3.3 4.201e-05 0 5e-05 0 5.001e-05 3.3 5.4e-05 3.3 5.401e-05 0 5.8e-05 0 5.801e-05 3.3 6.6e-05 3.3 6.601e-05 0 7e-05 0 7.001e-05 3.3 7.4e-05 3.3 7.401e-05 0 7.8e-05 0 7.801e-05 3.3 8.2e-05 3.3 8.201e-05 0 0.000118 0 0.000118 3.3 0.000122 3.3 0.000122 0 0.000126 0 0.000126 3.3 0.000162 3.3 0.000162 0 0.000166 0 0.000166 3.3 0.00017 3.3 0.00017 0 0.000174 0 0.000174 3.3 0.000178 3.3 0.000178 0 0.000182 0 0.000182 3.3 0.000186 3.3 0.000186 0 0.00019 0 0.00019 3.3 0.000194 3.3 0.000194 0 0.000198 0 0.000198 3.3 0.000204 3.3)
Resp txi s 40
R5 s v33 10k
Ccable s 0 30p
XQ1 d v33 s Q2N7000
R6 d v5 10k
Cmega d 0 10p
Ctrace d 0 10p
.tran 10n 0.000204
.control
run
wrdata _link_esp_to_mega.txt v(s) v(d)
.endc
.end
