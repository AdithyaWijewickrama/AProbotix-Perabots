* power path, battery 7.4 V open circuit
.include models.lib
* 2S 1500 mAh LiPo: 2 x 25 mohm cells, XT60 + 5 A fuse + switch + 20 AWG leads: 50 mohm
Vcell cell 0 7.4
Rint cell bt 0.05
Rwire bt vbat 0.05
C3 vbat 0 100u
* DRV8833 + 2 x N20 6 V: both motors start from standstill at 80 % PWM (stall: 2 x ~1 A averaged)
* from 5 ms to 25 ms; the DRV8833 has no current limit fitted on our carrier
Smot vbat mot ctl_m 0 SWM
Rmot mot 0 { 1 / (2 * 0.8 * 0.8) * 7 }
Vctl_m ctl_m 0 PULSE(0 1 5m 10u 10u 20m 100m)
.model SWM SW(VT=0.5 RON=0.01 ROFF=1e9)
* logic buck LM2596 -> +5V: Mega + ESP32-S3 + OV7670 + 8 ToF + QTR + sonars + OLED + TCS LEDs = 0.35 A base,
* ESP32-S3 + OV7670 current step (CPU, PSRAM, camera; no Wi-Fi) +0.3 A at 12 ms .. 14 ms - conservative
X5 vbat p5 0 BUCK params: vset=5.0 vdrop=0.6 rsw=0.25 eff=0.85
C1 p5 c1e 470u
Rc1 c1e 0 0.05
Rlog p5 0 { 5 / 0.35 }
Sburst p5 bur ctl_b 0 SWM
Rbur bur 0 { 5 / 0.3 }
Vctl_b ctl_b 0 PULSE(0 1 12m 10u 10u 2m 100m)
* servo buck HW-319 -> +5V5: both M0170 servos (2 x 1.5 A) and the v4.2 SG90 camera tilt servo (0.75 A) stall at once, 10 ms .. 30 ms
X55 vbat p55 0 BUCK params: vset=5.5 vdrop=0.5 rsw=0.15 eff=0.88
C2 p55 c2e 470u
Rc2 c2e 0 0.05
Ridle p55 0 { 5.5 / 0.02 }
Ssrv p55 srv ctl_s 0 SWM
Rsrv srv 0 { 5.5 / 3.75 }
Vctl_s ctl_s 0 PULSE(0 1 10m 10u 10u 20m 100m)
.tran 5u 40m
.control
run
wrdata _power_nominal.txt v(vbat) v(p5) v(p55)
.endc
.end
